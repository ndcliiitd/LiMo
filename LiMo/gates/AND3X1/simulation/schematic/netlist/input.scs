// Design: cad045/AND3X1
simulator lang=spectre
global 0
parameters skew_c=3e-10 skew_b=2.5e-10 VDD=1.2 corners=tt slew_c=1e-10 slew_b=1e-10 slew_a=1e-10 cap=1e-14
include "/cadence/FOUNDRY/analog/45nm/gpdk045/../models/spectre/gpdk045.scs" section=tt

// cad045/AND3X1/schematic
NM3 (Y net7 VSS VSS) g45n1svt w=(260n) l=45n nf=1 m=(1)
NM2 (net2 A VSS VSS) g45n1svt w=(145n) l=45n nf=1 m=(1)
NM1 (net1 B net2 VSS) g45n1svt w=(145n) l=45n nf=1 m=(1)
NM0 (net7 C net1 VSS) g45n1svt w=(145n) l=45n nf=1 m=(1)
PM3 (Y net7 VDD VDD) g45p1svt w=(390n) l=45n nf=1 m=(1)
PM2 (net7 A VDD VDD) g45p1svt w=(215n) l=45n nf=1 m=(1)
PM1 (net7 B VDD VDD) g45p1svt w=(215n) l=45n nf=1 m=(1)
PM0 (net7 C VDD VDD) g45p1svt w=(215n) l=45n nf=1 m=(1)
C0 (Y VSS) capacitor c=cap
include "/home/poojabe/Desktop/PhD_Research/src_project/ml_lib_char/gates/AND3X1/simulation/AND3X1/spectre/schematic/netlist/_graphical_stimuli_1.scs"
simulatorOptions options temp=25.0
tran tran stop=21e-9 start=0 step=0.1e-9
saveOptions options currents=all
