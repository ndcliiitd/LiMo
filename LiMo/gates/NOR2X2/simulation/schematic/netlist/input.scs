// Design: cad45nm/NOR2X2
simulator lang=spectre
global 0
parameters skew_b=1.1e-09 VDD=1.0 corners=tt slew_b=2.7e-10 slew_a=2.7e-10 cap=2.7e-13
include "/cadence/FOUNDRY/analog/45nm/gpdk045/../models/spectre/gpdk045.scs" section=tt

// cad45nm/NOR2X2/schematic
mn1 (Y B VSS VSS) g45n1svt w=(580n) l=45n nf=1 m=(1)
mn0 (Y A VSS VSS) g45n1svt w=(520n) l=45n nf=1 m=(1)
mp0 (net20 A VDD VDD) g45p1svt w=(780n) l=45n nf=1 m=(1)
mp1 (Y B net20 VDD) g45p1svt w=(780n) l=45n nf=1 m=(1)
C0 (Y VSS) capacitor c=cap
include "/home/ananya22131/Pooja_mam_project2/NOR2X2/simulation/NOR2X2/spectre/schematic/netlist/_graphical_stimuli_1.scs"
simulatorOptions options temp=25.0
tran tran stop=11e-9 start=0 step=0.1e-9
saveOptions options currents=all
