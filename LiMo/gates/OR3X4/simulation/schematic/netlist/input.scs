// Design: cad045/OR3X4
simulator lang=spectre
global 0
include "/cadence/FOUNDRY/analog/45nm/gpdk045/../models/spectre/gpdk045.scs" section=mc

// cad045/OR3X4/schematic
PM3 (Y net30 VDD VDD) g45p1svt w=(1.56u) l=45n nf=1 m=(1)
PM2 (net29 C VDD VDD) g45p1svt w=(390n) l=45n nf=1 m=(1)
PM1 (net30 A net31 VDD) g45p1svt w=(390n) l=45n nf=1 m=(1)
PM0 (net31 B net29 VDD) g45p1svt w=(390n) l=45n nf=1 m=(1)
NM3 (Y net30 VSS VSS) g45n1svt w=(1.04u) l=45n nf=1 m=(1)
NM2 (net30 C VSS VSS) g45n1svt w=(260n) l=45n nf=1 m=(1)
NM1 (net30 B VSS VSS) g45n1svt w=(260n) l=45n nf=1 m=(1)
NM0 (net30 A VSS VSS) g45n1svt w=(260n) l=45n nf=1 m=(1)
C0 (Y VSS) capacitor c=30f
include "./_graphical_stimuli.scs"
simulatorOptions options temp=27
tran tran stop=100n
