// Design: cad045/NOR3X8
simulator lang=spectre
global 0
include "/cadence/FOUNDRY/analog/45nm/gpdk045/../models/spectre/gpdk045.scs" section=mc

// cad045/NOR3X8/schematic
mn2 (Y C VSS VSS) g45n1svt w=(2.065u) l=45n nf=1 m=(1)
mn1 (Y B VSS VSS) g45n1svt w=(2.065u) l=45n nf=1 m=(1)
mn0 (Y A VSS VSS) g45n1svt w=(2.065u) l=45n nf=1 m=(1)
mp2 (Y C n1 VDD) g45p1svt w=(3.115u) l=45n nf=1 m=(1)
mp1 (n1 B n0 VDD) g45p1svt w=(3.115u) l=45n nf=1 m=(1)
mp0 (n0 A VDD VDD) g45p1svt w=(3.115u) l=45n nf=1 m=(1)
C0 (Y VSS) capacitor c=30f
include "./_graphical_stimuli.scs"
simulatorOptions options temp=27
tran tran stop=100n
