// Design: combCell45nm/NOR3X1
simulator lang=spectre
global 0
parameters skew_c=1e-09 skew_b=1e-09 VDD=1.2 corners=tt slew_c=1e-10 slew_b=1e-10 slew_a=1e-10 cap=3e-13
include "/cadence/FOUNDRY/analog/45nm/gpdk045/../models/spectre/gpdk045.scs" section=tt

// combCell45nm/NOR3X1/schematic
PM2 (Y C net23 VDD) g45p1svt w=(390n) l=45n nf=1 m=(1)
PM1 (net23 B net24 VDD) g45p1svt w=(390n) l=45n nf=1 m=(1)
PM0 (net24 A VDD VDD) g45p1svt w=(390n) l=45n nf=1 m=(1)
NM2 (Y A VSS VSS) g45n1svt w=(260n) l=45n nf=1 m=(1)
NM1 (Y C VSS VSS) g45n1svt w=(260n) l=45n nf=1 m=(1)
NM0 (Y B VSS VSS) g45n1svt w=(260n) l=45n nf=1 m=(1)
C0 (Y VSS) capacitor c=cap
include "/home/poojabe/Desktop/PhD_Research/src_project/ml_lib_char/gates/NOR3X1/simulation/NOR3X1/spectre/schematic/netlist/_graphical_stimuli_1.scs"
simulatorOptions options temp=25.0
tran tran stop=21e-9 start=0 step=0.1e-9
saveOptions options currents=all
