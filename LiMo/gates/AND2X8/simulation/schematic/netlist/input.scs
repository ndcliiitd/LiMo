// Design: cad45nm/AND2X8
simulator lang=spectre
global 0
parameters skew_b=3e-10 VDD=1.0 corners=tt slew_b=2.7e-10 slew_a=2.7e-10 cap=2.7e-13
include "/cadence/FOUNDRY/analog/45nm/gpdk045/../models/spectre/gpdk045.scs" section=tt

// cad45nm/AND2X8/schematic
PM1 (net23 B VDD VDD) g45p1svt w=(780n) l=45n nf=1 m=(1)
PM0 (net23 A VDD VDD) g45p1svt w=(780n) l=45n nf=1 m=(1)
PM2 (Y net23 VDD VDD) g45p1svt w=(3.11u) l=45n nf=1 m=(1)
C0 (Y VSS) capacitor c=cap
NM0 (net23 A net24 VSS) g45n1svt w=(520n) l=45n nf=1 m=(1)
NM2 (Y net23 VSS VSS) g45n1svt w=(2.065u) l=45n nf=1 m=(1)
NM1 (net24 B VSS VSS) g45n1svt w=(520n) l=45n nf=1 m=(1)
include "/home/ananya22131/Pooja_mam_project2/AND2X8/simulation/AND2X8/spectre/schematic/netlist/_graphical_stimuli_1.scs"
simulatorOptions options temp=25.0
tran tran stop=11e-9 start=0 step=0.1e-9
saveOptions options currents=all
