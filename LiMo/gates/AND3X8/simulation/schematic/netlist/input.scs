// Design: cad045/AND3X8
simulator lang=spectre
global 0
include "/cadence/FOUNDRY/analog/45nm/gpdk045/../models/spectre/gpdk045.scs" section=mc

// cad045/AND3X8/schematic
C0 (Y VSS) capacitor c=30f
mn0 (net43 C VSS VSS) g45n1svt w=(520n) l=45n nf=1 m=(1)
mn3 (Y net42 VSS VSS) g45n1svt w=(2.065u) l=45n nf=1 m=(1)
mn1 (net44 B net43 VSS) g45n1svt w=(520n) l=45n nf=1 m=(1)
mn2 (net42 A net44 VSS) g45n1svt w=(520n) l=45n nf=1 m=(1)
mp3 (Y net42 VDD VDD) g45p1svt w=(3.115u) l=45n nf=1 m=(1)
mp0 (net42 C VDD VDD) g45p1svt w=(780n) l=45n nf=1 m=(1)
mp2 (net42 A VDD VDD) g45p1svt w=(780n) l=45n nf=1 m=(1)
mp1 (net42 B VDD VDD) g45p1svt w=(780n) l=45n nf=1 m=(1)
include "./_graphical_stimuli.scs"
simulatorOptions options temp=27
tran tran stop=100n
