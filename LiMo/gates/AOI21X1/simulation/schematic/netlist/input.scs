// Design: cad045/AOI21
simulator lang=spectre
global 0
parameters skew_c=4.5e-10 skew_b=3e-10 VDD=1.2 corners=tt slew_c=1e-10 slew_b=1e-10 slew_a=1e-10 cap=1e-14
include "/cadence/FOUNDRY/analog/45nm/gpdk045/../models/spectre/gpdk045.scs" section=tt

// cad045/AOI21/schematic
C0 (Y VSS) capacitor c=cap
NM2 (Y A VSS VSS) g45n1svt w=(260n) l=45n nf=1 m=(1)
NM1 (Y B net2 VSS) g45n1svt w=(260n) l=45n nf=1 m=(1)
NM0 (net2 C VSS VSS) g45n1svt w=(260n) l=45n nf=1 m=(1)
PM2 (net1 C VDD VDD) g45p1svt w=(390n) l=45n nf=1 m=(1)
PM1 (net1 B VDD VDD) g45p1svt w=(390n) l=45n nf=1 m=(1)
PM0 (Y A net1 VDD) g45p1svt w=(390n) l=45n nf=1 m=(1)
include "/home/poojabe/Desktop/PhD_Research/src_project/ml_lib_char/gates/AOI21X1/simulation/AOI21X1/spectre/schematic/netlist/_graphical_stimuli_1.scs"
simulatorOptions options temp=25.0
tran tran stop=21e-9 start=0 step=0.1e-9
saveOptions options currents=all
