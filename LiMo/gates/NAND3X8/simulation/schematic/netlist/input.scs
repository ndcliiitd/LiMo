// Design: cad045/NAND3X8
simulator lang=spectre
global 0
include "/cadence/FOUNDRY/analog/45nm/gpdk045/../models/spectre/gpdk045.scs" section=mc

// cad045/NAND3X8/schematic
mp2 (Y B VDD VDD) g45p1svt w=(3.115u) l=45n nf=1 m=(1)
mp1 (Y C VDD VDD) g45p1svt w=(3.115u) l=45n nf=1 m=(1)
mp0 (Y A VDD VDD) g45p1svt w=(3.115u) l=45n nf=1 m=(1)
mn0 (n1 A VSS VSS) g45n1svt w=(2.065u) l=45n nf=1 m=(1)
mn1 (n0 C n1 VSS) g45n1svt w=(2.065u) l=45n nf=1 m=(1)
mn2 (Y B n0 VSS) g45n1svt w=(2.065u) l=45n nf=1 m=(1)
include "./_graphical_stimuli.scs"
simulatorOptions options temp=27
tran tran stop=100n
