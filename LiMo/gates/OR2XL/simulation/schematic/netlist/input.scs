// Design: cad45nm/OR2XL
simulator lang=spectre
global 0
parameters skew_b=2.3e-09 VDD=1.0 corners=tt slew_b=2.7e-10 slew_a=2.7e-10 cap=2.7e-13
include "/cadence/FOUNDRY/analog/45nm/gpdk045/../models/spectre/gpdk045.scs" section=tt

// cad45nm/OR2XL/schematic
mn1 (n0 B VSS VSS) g45n1svt w=(145n) l=45n nf=1 m=(1)
mn0 (n0 A VSS VSS) g45n1svt w=(145n) l=45n nf=1 m=(1)
mn2 (Y n0 VSS VSS) g45n1svt w=(145n) l=45n nf=1 m=(1)
mp1 (n0 B n1 VDD) g45p1svt w=(215n) l=45n nf=1 m=(1)
mp0 (n1 A VDD VDD) g45p1svt w=(215n) l=45n nf=1 m=(1)
mp2 (Y n0 VDD VDD) g45p1svt w=(215n) l=45n nf=1 m=(1)
C0 (Y VSS) capacitor c=cap
include "/home/ananya22131/Pooja_mam_project2/OR2XL/simulation/OR2XL/spectre/schematic/netlist/_graphical_stimuli_1.scs"
simulatorOptions options temp=25.0
tran tran stop=11e-9 start=0 step=0.1e-9
saveOptions options currents=all
