// Design: cad45nm/AND2X4
simulator lang=spectre
global 0
parameters skew_b=4.5e-10 VDD=1.0 corners=tt slew_b=2.7e-10 slew_a=2.7e-10 cap=2.7e-13
include "/cadence/FOUNDRY/analog/45nm/gpdk045/../models/spectre/gpdk045.scs" section=tt

// cad45nm/AND2X4/schematic
NM1 (net23 B VSS VSS) g45n1svt w=(260n) l=45n nf=1 m=(1)
NM2 (Y net24 VSS VSS) g45n1svt w=(1.04u) l=45n nf=1 m=(1)
NM0 (net24 A net23 VSS) g45n1svt w=(260n) l=45n nf=1 m=(1)
C0 (Y VSS) capacitor c=cap
PM2 (Y net24 VDD VDD) g45p1svt w=(1.56u) l=45n nf=1 m=(1)
PM0 (net24 A VDD VDD) g45p1svt w=(390n) l=45n nf=1 m=(1)
PM1 (net24 B VDD VDD) g45p1svt w=(390n) l=45n nf=1 m=(1)
include "/home/ananya22131/Pooja_mam_project2/AND2X4/simulation/AND2X4/spectre/schematic/netlist/_graphical_stimuli_1.scs"
simulatorOptions options temp=25.0
tran tran stop=11e-9 start=0 step=0.1e-9
saveOptions options currents=all
