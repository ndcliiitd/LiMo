// Design: cad45nm/OAI21X1
simulator lang=spectre
global 0
parameters skew_c=1e-09 skew_b=1e-09 VDD=1.2 corners=tt slew_c=1e-10 slew_b=1e-10 slew_a=1e-10 cap=3e-13
include "/cadence/FOUNDRY/analog/45nm/gpdk045/../models/spectre/gpdk045.scs" section=tt

// cad45nm/OAI21X1/schematic
C0 (Y VSS) capacitor c=cap
NM2 (Y A net3 VSS) g45n1svt w=(145n) l=45n nf=1 m=(1)
NM1 (net3 B VSS VSS) g45n1svt w=(145n) l=45n nf=1 m=(1)
NM0 (net3 C VSS VSS) g45n1svt w=(145n) l=45n nf=1 m=(1)
PM2 (net2 C VDD VDD) g45p1svt w=(215n) l=45n nf=1 m=(1)
PM1 (Y B net2 VDD) g45p1svt w=(215n) l=45n nf=1 m=(1)
PM0 (Y A VDD VDD) g45p1svt w=(215n) l=45n nf=1 m=(1)
include "/home/ananya22131/Pooja_mam_project2/OAI21X1/simulation/OAI21X1/spectre/schematic/netlist/_graphical_stimuli_1.scs"
simulatorOptions options temp=25.0
tran tran stop=21e-9 start=0 step=0.1e-9
saveOptions options currents=all
