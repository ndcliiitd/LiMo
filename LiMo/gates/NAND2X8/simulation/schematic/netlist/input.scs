// Design: cad45nm/NAND2X8
simulator lang=spectre
global 0
parameters skew_b=2e-09 VDD=1.2 corners=tt slew_b=1e-10 slew_a=1e-10 cap=1e-13
include "/cadence/FOUNDRY/analog/45nm/gpdk045/../models/spectre/gpdk045.scs" section=tt

// cad45nm/NAND2X8/schematic
C0 (Y VSS) capacitor c=cap
mn1 (Y B n0 VSS) g45n1svt w=(2.065u) l=45n nf=1 m=(1)
mn0 (n0 A VSS VSS) g45n1svt w=(2.065u) l=45n nf=1 m=(1)
mp1 (Y B VDD VDD) g45p1svt w=(3.115u) l=45n nf=1 m=(1)
mp0 (Y A VDD VDD) g45p1svt w=(3.115u) l=45n nf=1 m=(1)
include "/home/poojabe/Desktop/PhD_Research/src_project/ml_lib_char/mlLibGen/gates/NAND2X8/simulation/NAND2X8/spectre/schematic/netlist/_graphical_stimuli_1.scs"
simulatorOptions options temp=25.0
tran tran stop=26e-9 start=0 step=0.1e-9
saveOptions options currents=all
