// Design: combCell45nm/NAND2X1
simulator lang=spectre
global 0
parameters skew_b=9.5e-10 VDD=1.0 corners=tt slew_b=1e-11 slew_a=1e-11 cap=1e-14
include "/cadence/FOUNDRY/analog/45nm/gpdk045/../models/spectre/gpdk045.scs" section=tt

// combCell45nm/NAND2X1/schematic
PM1 (Y B VDD VDD) g45p1svt w=(390n) l=45n nf=1 m=(1)
PM0 (Y A VDD VDD) g45p1svt w=(390n) l=45n nf=1 m=(1)
NM1 (net7 A VSS VSS) g45n1svt w=(260n) l=45n nf=1 m=(1)
NM0 (Y B net7 VSS) g45n1svt w=(260n) l=45n nf=1 m=(1)
C0 (Y VSS) capacitor c=cap
include "/home/poojabe/Desktop/PhD_Research/src_project/ml_lib_char/Limo/gates/NAND2X1/simulation/schematic/netlist/_graphical_stimuli_1.scs"
simulatorOptions options temp=25.0
tran tran stop=21e-9 start=0 step=0.1e-9
saveOptions options currents=all
