// Design: cad45nm/NOR2X8
simulator lang=spectre
global 0
parameters skew_b=5e-10 VDD=1.0 corners=tt slew_b=2.7e-10 slew_a=2.7e-10 cap=2.7e-13
include "/cadence/FOUNDRY/analog/45nm/gpdk045/../models/spectre/gpdk045.scs" section=tt

// cad45nm/NOR2X8/schematic
C0 (Y VSS) capacitor c=cap
mn1 (Y B VSS VSS) g45n1svt w=(2.065u) l=45n nf=1 m=(1)
mn0 (Y A VSS VSS) g45n1svt w=(2.065u) l=45n nf=1 m=(1)
mp0 (net33 A VDD VDD) g45p1svt w=(3.115u) l=45n nf=1 m=(1)
mp1 (Y B net33 VDD) g45p1svt w=(3.115u) l=45n nf=1 m=(1)
include "/home/ananya22131/Pooja_mam_project2/NOR2X8/simulation/NOR2X8/spectre/schematic/netlist/_graphical_stimuli_1.scs"
simulatorOptions options temp=25.0
tran tran stop=11e-9 start=0 step=0.1e-9
saveOptions options currents=all
