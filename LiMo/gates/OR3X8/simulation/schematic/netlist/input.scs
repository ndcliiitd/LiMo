// Design: cad045/OR3X8
simulator lang=spectre
global 0
include "/cadence/FOUNDRY/analog/45nm/gpdk045/../models/spectre/gpdk045.scs" section=mc

// cad045/OR3X8/schematic
C0 (Y VSS) capacitor c=30f
NM0 (net29 A VSS VSS) g45n1svt w=(520n) l=45n nf=1 m=(1)
NM1 (net29 B VSS VSS) g45n1svt w=(520n) l=45n nf=1 m=(1)
NM2 (net29 C VSS VSS) g45n1svt w=(520n) l=45n nf=1 m=(1)
NM3 (Y net29 VSS VSS) g45n1svt w=(2.065u) l=45n nf=1 m=(1)
PM0 (net31 B net30 VDD) g45p1svt w=(780n) l=45n nf=1 m=(1)
PM1 (net29 A net31 VDD) g45p1svt w=(780n) l=45n nf=1 m=(1)
PM2 (net30 C VDD VDD) g45p1svt w=(780n) l=45n nf=1 m=(1)
PM3 (Y net29 VDD VDD) g45p1svt w=(3.115u) l=45n nf=1 m=(1)
include "./_graphical_stimuli.scs"
simulatorOptions options temp=27
tran tran stop=100n
